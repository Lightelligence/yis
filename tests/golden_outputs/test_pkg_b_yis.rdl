// Copyright (c) 2023 Lightelligence
//
// Description: RDL Pkg generated from test_pkg_b.yis by YIS




`define TEST_PKG_B_NEW_PARAM 3 // This should link up to [test_pkg_a::ANOTHER_PARAM]

`define TEST_PKG_B_NEW_PARAM_WIDTH /* clog2(NEW_PARAM.value) */ 2 // Width of NEW_PARAM

`define TEST_PKG_B_NEW_PARAM_COUNT_WIDTH /* clog2(NEW_PARAM.value + 1) */ 2 // Width to count NEW_PARAM items

`define TEST_PKG_B_NEW_PARAM_WIDTH_ONE 1 // NEW_PARAM_WIDTH-wide 1 for incrementers and decrementers

`define TEST_PKG_B_NEW_PARAM_COUNT_ONE 1 // NEW_PARAM_COUNT_WIDTH-wide 1 for incrementers and decrementers

`define TEST_PKG_B_MAX_WR_CYCLES 4 // Maximum number of write cycles allowed for the pipelined write

`define TEST_PKG_B_MAX_WR_CYCLES_WIDTH /* clog2(MAX_WR_CYCLES.value) */ 2 // Width of MAX_WR_CYCLES

`define TEST_PKG_B_MAX_WR_CYCLES_WIDTH_2 2 // a 2 that is MAX_WR_CYCLES_WIDTH-wide (am implicit localparam generated by YIS)

`define TEST_PKG_B_MAX_WR_CYCLES_WIDTH_2_WIDTH /* clog2(MAX_WR_CYCLES_WIDTH_2.value) */ 1 // Width of MAX_WR_CYCLES_WIDTH_2

`define TEST_PKG_B_MAX_WR_CYCLES_WIDTH_2_COUNT_WIDTH /* clog2(MAX_WR_CYCLES_WIDTH_2.value + 1) */ 2 // Width to count MAX_WR_CYCLES_WIDTH_2 items

`define TEST_PKG_B_MAX_WR_CYCLES_WIDTH_2_WIDTH_ONE 1 // MAX_WR_CYCLES_WIDTH_2_WIDTH-wide 1 for incrementers and decrementers

`define TEST_PKG_B_MAX_WR_CYCLES_WIDTH_2_COUNT_ONE 1 // MAX_WR_CYCLES_WIDTH_2_COUNT_WIDTH-wide 1 for incrementers and decrementers

`define TEST_PKG_B_MAX_WR_CYCLES_COUNT_WIDTH /* clog2(MAX_WR_CYCLES.value + 1) */ 3 // Width to count MAX_WR_CYCLES items

`define TEST_PKG_B_MAX_WR_CYCLES_WIDTH_ONE 1 // MAX_WR_CYCLES_WIDTH-wide 1 for incrementers and decrementers

`define TEST_PKG_B_MAX_WR_CYCLES_COUNT_ONE 1 // MAX_WR_CYCLES_COUNT_WIDTH-wide 1 for incrementers and decrementers

`define TEST_PKG_B_WR_WIDTH 8 // Width of a single write cycle

`define TEST_PKG_B_WR_WIDTH_WIDTH /* clog2(WR_WIDTH.value) */ 3 // Width of WR_WIDTH

`define TEST_PKG_B_WR_WIDTH_COUNT_WIDTH /* clog2(WR_WIDTH.value + 1) */ 4 // Width to count WR_WIDTH items

`define TEST_PKG_B_WR_WIDTH_WIDTH_ONE 1 // WR_WIDTH_WIDTH-wide 1 for incrementers and decrementers

`define TEST_PKG_B_WR_WIDTH_COUNT_ONE 1 // WR_WIDTH_COUNT_WIDTH-wide 1 for incrementers and decrementers

// Used to verify logic fields of width 1 in a a struct via an
  // equation.
  `define TEST_PKG_B_THIS_IS_ONE 1 // A localparam value of 1

`define TEST_PKG_B_THIS_IS_ONE_WIDTH /* clog2(THIS_IS_ONE.value) */ 0 // Width of THIS_IS_ONE

`define TEST_PKG_B_THIS_IS_ONE_COUNT_WIDTH /* clog2(THIS_IS_ONE.value + 1) */ 1 // Width to count THIS_IS_ONE items

// Width would be 0 because clog2(1)=0. Forcing to 1.
  `define TEST_PKG_B_THIS_IS_ONE_WIDTH_ONE 1 // THIS_IS_ONE_WIDTH-wide 1 for incrementers and decrementers

`define TEST_PKG_B_THIS_IS_ONE_COUNT_ONE 1 // THIS_IS_ONE_COUNT_WIDTH-wide 1 for incrementers and decrementers

// This enum's values don't follow from 0 to N, in order to
  // demonstrate the feature
  enum WRITE_TYPE_E {
    WRITE_TYPE_STD = 1; // Standard write, nothing special
    WRITE_TYPE_MULTI_WDONE = 3; // Send a wdone for each individual cycle completing
    WRITE_TYPE_SINGLE_WDONE = 7; // Send a wdone only for the entire write xaction
  }; // Specifies how the write should be handled

`define TEST_PKG_B_WRITE_TYPE_E_WIDTH /* WRITE_TYPE_E.width */ 3 // Width of WRITE_TYPE_E



`define TEST_PKG_B_SEVERAL_THINGS_T_WIDTH /* several_things_t.width */ 101 // Width of several_things_t







`define TEST_PKG_B_TYPE_LINKS_T_WIDTH /* type_links_t.width */ 128 // Width of type_links_t

reg test_pkg_b_write_cmd_t {
  desc = "The command cycle of a pipelined write";
  field {encode=WRITE_TYPE_E; render_encode_pkg="test_pkg_b_rypkg"; desc = "Specifies how the write should be handled: STD - 1; MULTI_WDONE - 3; SINGLE_WDONE - 7";} write_type[3];
  field {desc = "Number of cycles for this write. 0 indicates MAX_WRITE_CYCLES, otherwise indicates the regular value";} num_cycles[2];
  field {desc = "Reserved";} rsvd[4];
  field {desc = "This cmd is valid, this is the start of a new pipelined write";} vld[1];
};

`define TEST_PKG_B_WRITE_CMD_T_WIDTH /* write_cmd_t.width */ 10 // Width of write_cmd_t

reg test_pkg_b_write_dat_t {
  desc = "Data cycle of a pipelined write";
  field {desc = "One data cycle";} dat[8];
  field {encode=CYCLE_TYPE_E; render_encode_pkg="test_pkg_a_rypkg"; desc = "Indicates a command type of IDLE, VALID, or DONE.: IDLE - 0; VALID - 1; DONE - 2";} cycle_type[2];
};

`define TEST_PKG_B_WRITE_DAT_T_WIDTH /* write_dat_t.width */ 10 // Width of write_dat_t

reg test_pkg_b_one_bit_field_t {
  desc = "Struct to hold 1-bit bit fields to make sure the 1-bit rendering is correct";
  field {desc = "This field should be rendered to just a bare logic with the equation in comments";} simple_bit_field[1];
  field {desc = "This field should be rendered to just a bare logic with the equation in comments";} new_bit_field[1];
  field {desc = "This field should be rendered as bare logic without anything else";} vld[1];
};

`define TEST_PKG_B_ONE_BIT_FIELD_T_WIDTH /* one_bit_field_t.width */ 3 // Width of one_bit_field_t

`define TEST_PKG_B_FIRST_DEFINED_TYPE_T_WIDTH /* first_defined_type_t.width */ 6 // Width of first_defined_type_t

`define TEST_PKG_B_SECOND_DEFINED_TYPE_T_WIDTH /* second_defined_type_t.width */ 120 // Width of second_defined_type_t



`define TEST_PKG_B_LOCAL_ITEM_TYPE_T_WIDTH /* local_item_type_t.width */ 202 // Width of local_item_type_t



`define TEST_PKG_B_TYPE_FROM_IMPLICIT_PARAM_T_WIDTH /* type_from_implicit_param_t.width */ 2 // Width of type_from_implicit_param_t



`define TEST_PKG_B_WIDTH_ONE_TYPEDEF_T_WIDTH /* width_one_typedef_t.width */ 1 // Width of width_one_typedef_t



`define TEST_PKG_B_WIDTH_ONE_EQN_TYPEDEF_T_WIDTH /* width_one_eqn_typedef_t.width */ 1 // Width of width_one_eqn_typedef_t



